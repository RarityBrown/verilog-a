`include "constants.vams"
`include "disciplines.vams"

module counter (clk, rst, out_bus);
    input clk, rst;
    output [31:0] out_bus;
    electrical clk, rst;
    electrical [31:0] out_bus;

    parameter real vdd = 1.0;
    parameter real vss = 0.0;
    parameter real vth = 0.5;
    parameter real tr = 10p;
    parameter real tf = 10p;
    parameter integer edges_per_count = 1;

    // 0: binary, 1: one-hot, 2: thermometer, 3+: reserved
    parameter integer encode_mode = 0;

    integer count;
    integer edge_counter;
    integer max_count;
    genvar i;

    analog begin
        @(initial_step) begin
            count = 0;
            edge_counter = 0;

            if (encode_mode == 1)      max_count = 32;
            else if (encode_mode == 2) max_count = 33;
            else                       max_count = 0;
        end

        @(cross(V(rst) - vth, 1)) begin
            count = 0;
            edge_counter = 0;
        end

        @(cross(V(clk) - vth, 1)) begin
            if (V(rst) < vth) begin
                edge_counter = edge_counter + 1;
                if (edge_counter >= edges_per_count) begin
                    count = count + 1;
                    if (max_count > 0 && count >= max_count) begin
                        count = 0;
                    end
                    edge_counter = 0;
                end
            end
        end

        for (i = 0; i < 32; i = i + 1) begin
            if (encode_mode == 1) begin
                V(out_bus[i]) <+ transition((count == i) ? vdd : vss, 0, tr, tf);
            end
            else if (encode_mode == 2) begin
                V(out_bus[i]) <+ transition((count > i) ? vdd : vss, 0, tr, tf);
            end
            else begin
                V(out_bus[i]) <+ transition(((count >> i) & 1) ? vdd : vss, 0, tr, tf);
            end
        end
    end
endmodule
