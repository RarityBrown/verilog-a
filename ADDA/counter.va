`include "constants.vams"
`include "disciplines.vams"

module counter (clk, rst, out_bus);
    input clk, rst;
    output [11:0] out_bus;
    electrical clk, rst;
    electrical [11:0] out_bus;

    parameter real vdd = 1.0;
    parameter real vss = 0.0;
    parameter real vth = 0.5;
    parameter real tr = 10p;
    parameter real tf = 10p;
    parameter integer edges_per_count = 1;

    integer count;
    integer edge_counter;
    genvar i;

    analog begin
        @(initial_step) begin
            count = 0;
            edge_counter = 0;
        end

        @(cross(V(rst) - vth, 1)) begin
            count = 0;
            edge_counter = 0;
        end

        @(cross(V(clk) - vth, 1)) begin
            if (V(rst) < vth) begin
                edge_counter = edge_counter + 1;
                if (edge_counter >= edges_per_count) begin
                    count = (count + 1) % 4096;
                    edge_counter = 0;
                end
            end
        end

        for (i = 0; i < 12; i = i + 1) begin
            V(out_bus[i]) <+ transition(((count >> i) & 1) ? vdd : vss, 0, tr, tf);
        end
    end
endmodule
