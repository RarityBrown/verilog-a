`include "constants.vams"
`include "disciplines.vams"

module dac_sar_9bit(bin, vout);
    input [8:0] bin;
    output vout;

    electrical [8:0] bin;
    electrical vout;

    parameter real vref   = 1.0;
    parameter real vtrans = 0.5;
    parameter real tdelay = 0;
    parameter real trise  = 1p;
    parameter real tfall  = 1p;

    genvar i;
    real dac_code;
    real vout_val;

    analog begin
        dac_code = 0;

        for (i = 0; i < 9; i = i + 1) begin
            if (V(bin[i]) > vtrans) begin
                dac_code = dac_code + (1 << i);
            end
        end

        vout_val = vref * (dac_code / 512.0);

        V(vout) <+ transition(vout_val, tdelay, trise, tfall);
    end

endmodule
